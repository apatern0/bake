* The LVS netlist of adc, without VSS
.SUBCKT adc clk start dout[2] dout[1] dout[0]
+ busy vin VDD
*.PININFO clk:I start:I dout[2]:O dout[1]:O dout[0]:O busy:O vin:B VDD:B
.ENDS
